ADE simulation setup
Run mode: Single Run, Sweeps and Corners
Tests:
  DVLSI2024_MVLSI02_DVLSI03_MVLSI02_DVLSI02_SCH:TB_BoothEncoder:1: DVLSI2024_MVLSI02_DVLSI03_MVLSI02_DVLSI02_SCH/TB_BoothEncoder/config, simulator spectre
