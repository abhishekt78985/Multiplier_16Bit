ADE simulation setup
Run mode: Single Run, Sweeps and Corners
Tests:
  DVLSI2024_MVLSI02_DVLSI03_MVLSI02_DVLSI02_SCH:MULTIPLIER_16BIT_TBA3:1: DVLSI2024_MVLSI02_DVLSI03_MVLSI02_DVLSI02_SCH/MULTIPLIER_16BIT_TBA3/config, simulator spectre
Global variables:
  vdc = 1
